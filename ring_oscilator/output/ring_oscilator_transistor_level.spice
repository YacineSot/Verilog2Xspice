* SPICE netlist generated by Yosys 0.70+336 (git sha1 8f3cc3d0c, Debug, GNU /usr/bin/c++ 16.2.1)

.include $::PDK_ROOT/$::PDK/libs.ref/sg13cmos5l_stdcell/spice/sg13cmos5l_stdcell.spice
.subckt ring_oscilator VDD VSS en osc
X0 osc n.9 VDD VSS sg13cmos5l_inv_1
X1 n.9 n.8 VDD VSS sg13cmos5l_inv_1
X2 n.8 n.7 VDD VSS sg13cmos5l_inv_1
X3 n.7 n.6 VDD VSS sg13cmos5l_inv_1
X4 n.6 n.5 VDD VSS sg13cmos5l_inv_1
X5 n.5 n.4 VDD VSS sg13cmos5l_inv_1
X6 n.4 n.3 VDD VSS sg13cmos5l_inv_1
X7 n.3 n.2 VDD VSS sg13cmos5l_inv_1
X8 n.2 n.1 VDD VSS sg13cmos5l_inv_1
X9 n.1 n.0 VDD VSS sg13cmos5l_inv_1
X10 n.0 en osc VDD VSS sg13cmos5l_nand2_1
V0 osc n.10 DC 0

.ends ring_oscilator
************************
* end of SPICE netlist *
************************
