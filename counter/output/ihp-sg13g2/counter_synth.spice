* SPICE netlist generated by Yosys 0.70+336 (git sha1 8f3cc3d0c, Debug, GNU /usr/bin/c++ 16.2.1)

X0 1.0 count.0 sg13g2_inv_1
X1 2.1 count.0 count.1 sg13g2_xor2_1
X2 3 count.0 count.1 count.2 sg13g2_nand3_1
X3 4 count.0 count.1 count.2 sg13g2_a21o_1
X4 2.2 3 4 sg13g2_and2_1
X5 2.3 count.3 3 sg13g2_xnor2_1
X6 count.0 clk 1.0 reset_n sg13g2_dfrbpq_1
X7 count.3 clk 2.3 reset_n sg13g2_dfrbpq_1
X8 count.2 clk 2.2 reset_n sg13g2_dfrbpq_1
X9 count.1 clk 2.1 reset_n sg13g2_dfrbpq_1
V0 count.1 1.1 DC 0
V1 count.2 1.2 DC 0
V2 count.3 1.3 DC 0
V3 1.0 2.0 DC 0

************************
* end of SPICE netlist *
************************
